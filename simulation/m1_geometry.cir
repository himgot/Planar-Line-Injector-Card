* m1a + m1b
* M1 geometry-only prediction (magnetic only). m1a: R_AC = 5.82, R_DC = 5.82 ohm (values_theory.json, drawn 0.254 mm x 35 um);
* m1b: R = 7.31 ohm (measured). L_AC 17.63, L_DC 17.64, M 16.59 uH (Neumann, top+via+bottom route), R_g = 50 ohm.
* Bench topology: V_g (AC 1 = generator EMF) -> R_g -> AC_IN; AC_RTN = 0; DC_IN = 0 (5 V rail is an AC ground);
* OUT -> R_L = 111.6 ohm -> 0. Measured quantity: V(<prefix>out) / V_g.
* Inductor dot = FIRST node; positive K = like-polarity first nodes (measured: AC_IN with OUT, AC_RTN with DC_IN).
* Winding resistance is an explicit resistor (R*_ser). LTspice adds its default 1 mohm inductor Rser; negligible here.
* Generated by analysis/circuit_models.py with analysis/mna_sim.py. Label: [MODEL].
Vg_m1a m1a_src 0 AC 1
Vg_m1b m1b_src 0 AC 1
Rg_m1a m1a_src m1a_ac_in 50
RAC_ser_m1a m1a_ac_in m1a_LAC_r 5.82
RDC_ser_m1a m1a_out m1a_LDC_r 5.82
RL_m1a m1a_out 0 111.6
Rg_m1b m1b_src m1b_ac_in 50
RAC_ser_m1b m1b_ac_in m1b_LAC_r 7.31
RDC_ser_m1b m1b_out m1b_LDC_r 7.31
RL_m1b m1b_out 0 111.6
LAC_m1a m1a_LAC_r 0 1.763e-05
LDC_m1a m1a_LDC_r 0 1.764e-05
LAC_m1b m1b_LAC_r 0 1.763e-05
LDC_m1b m1b_LDC_r 0 1.764e-05
K1 LAC_m1a LDC_m1a 0.940742879
K2 LAC_m1b LDC_m1b 0.940742879
.ac dec 250 10k 30Meg
.meas AC M1A_OUT_1MHz FIND V(m1a_out) AT 1Meg
.meas AC M1B_OUT_1MHz FIND V(m1b_out) AT 1Meg
.backanno
.end
