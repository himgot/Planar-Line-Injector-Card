* hr + hx
* M4 HYPOTHESES (not conclusions): parasitic sets that best reproduce the normalised bench curves.
* hr (Run R): base=M2, R_g=50 ohm, probe=x1_115pF, L_w=1 uH, L_RL=5 uH
* hx (Run X): base=M2, R_g=600 ohm, probe=none, L_w=0 uH, L_RL=4 uH
* Probe x1 = 1 Mohm || (15 pF + cable C); x10 = 10 Mohm || 12 pF; Lw = probe loop inductance between OUT and the probe;
* LRL = series inductance of the load resistor. Measured nodes: V(hr_meas) and V(hx_out).
* Bench topology: V_g (AC 1 = generator EMF) -> R_g -> AC_IN; AC_RTN = 0; DC_IN = 0 (5 V rail is an AC ground);
* OUT -> R_L = 111.6 ohm -> 0. Measured quantity: V(<prefix>out) / V_g.
* Inductor dot = FIRST node; positive K = like-polarity first nodes (measured: AC_IN with OUT, AC_RTN with DC_IN).
* Winding resistance is an explicit resistor (R*_ser). LTspice adds its default 1 mohm inductor Rser; negligible here.
* Generated by analysis/circuit_models.py with analysis/mna_sim.py. Label: [MODEL].
Vg_hr hr_src 0 AC 1
Vg_hx hx_src 0 AC 1
Rg_hr hr_src hr_ac_in 50
RAC_ser_hr hr_ac_in hr_LAC_r 7.31
RDC_ser_hr hr_out hr_LDC_r 7.31
RL_hr hr_out hr_rl_l 111.6
Rprobe_hr hr_meas 0 1e+06
Rg_hx hx_src hx_ac_in 600
RAC_ser_hx hx_ac_in hx_LAC_r 7.31
RDC_ser_hx hx_out hx_LDC_r 7.31
RL_hx hx_out hx_rl_l 111.6
Cprobe_hr hr_meas 0 1.15e-10
LAC_hr hr_LAC_r 0 1.794e-05
LDC_hr hr_LDC_r 0 1.796e-05
LRL_hr hr_rl_l 0 5e-06
Lw_hr hr_out hr_meas 1e-06
LAC_hx hx_LAC_r 0 1.794e-05
LDC_hx hx_LDC_r 0 1.796e-05
LRL_hx hx_rl_l 0 4e-06
K1 LAC_hr LDC_hr 0.909259194
K2 LAC_hx LDC_hx 0.909259194
.ac dec 250 10k 30Meg
.meas AC HR_MEAS_1MHz FIND V(hr_meas) AT 1Meg
.meas AC HX_OUT_1MHz FIND V(hx_out) AT 1Meg
.backanno
.end
