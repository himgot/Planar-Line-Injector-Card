* m2 + m3
* Corrected injector model (supersedes the 17 Nov schematic). Two independent circuits in one file:
* m2 = M2 lumped, measured L_A 17.94, L_B 17.96, M 16.3212 uH (k 0.9093), R 7.31 ohm each, R_g 50 ohm, R_L 111.6 ohm (data/values_meas.json).
* m3 = M3: M2 + 274 pF inter-winding C distributed over N=24 sections per winding. Section inductance matrix =
* PEEC partial inductances (data/model_inputs/peec_sections_N24.npz) scaled to the measured totals (AC x1.0255, DC x1.0254, cross x0.9882).
* Section i runs outer->inner. AC nodes: 0 (AC_RTN), m3_a1..m3_a23, m3_ac_in (AC_IN); DC nodes: 0 (DC_IN), m3_b1..m3_b23, m3_out (OUT).
* Change Rg_m2 / Rg_m3 to 600 for the 600-ohm generator setting.
* Bench topology: V_g (AC 1 = generator EMF) -> R_g -> AC_IN; AC_RTN = 0; DC_IN = 0 (5 V rail is an AC ground);
* OUT -> R_L = 111.6 ohm -> 0. Measured quantity: V(<prefix>out) / V_g.
* Inductor dot = FIRST node; positive K = like-polarity first nodes (measured: AC_IN with OUT, AC_RTN with DC_IN).
* Winding resistance is an explicit resistor (R*_ser). LTspice adds its default 1 mohm inductor Rser; negligible here.
* Generated by analysis/circuit_models.py with analysis/mna_sim.py. Label: [MODEL].
Vg_m2 m2_src 0 AC 1
Vg_m3 m3_src 0 AC 1
Rg_m2 m2_src m2_ac_in 50
RAC_ser_m2 m2_ac_in m2_LAC_r 7.31
RDC_ser_m2 m2_out m2_LDC_r 7.31
RL_m2 m2_out 0 111.6
Rg_m3 m3_src m3_ac_in 50
RA0_ser_m3 0 m3_LA0_r 0.304583
RA1_ser_m3 m3_a1 m3_LA1_r 0.304583
RA2_ser_m3 m3_a2 m3_LA2_r 0.304583
RA3_ser_m3 m3_a3 m3_LA3_r 0.304583
RA4_ser_m3 m3_a4 m3_LA4_r 0.304583
RA5_ser_m3 m3_a5 m3_LA5_r 0.304583
RA6_ser_m3 m3_a6 m3_LA6_r 0.304583
RA7_ser_m3 m3_a7 m3_LA7_r 0.304583
RA8_ser_m3 m3_a8 m3_LA8_r 0.304583
RA9_ser_m3 m3_a9 m3_LA9_r 0.304583
RA10_ser_m3 m3_a10 m3_LA10_r 0.304583
RA11_ser_m3 m3_a11 m3_LA11_r 0.304583
RA12_ser_m3 m3_a12 m3_LA12_r 0.304583
RA13_ser_m3 m3_a13 m3_LA13_r 0.304583
RA14_ser_m3 m3_a14 m3_LA14_r 0.304583
RA15_ser_m3 m3_a15 m3_LA15_r 0.304583
RA16_ser_m3 m3_a16 m3_LA16_r 0.304583
RA17_ser_m3 m3_a17 m3_LA17_r 0.304583
RA18_ser_m3 m3_a18 m3_LA18_r 0.304583
RA19_ser_m3 m3_a19 m3_LA19_r 0.304583
RA20_ser_m3 m3_a20 m3_LA20_r 0.304583
RA21_ser_m3 m3_a21 m3_LA21_r 0.304583
RA22_ser_m3 m3_a22 m3_LA22_r 0.304583
RA23_ser_m3 m3_a23 m3_LA23_r 0.304583
RB0_ser_m3 0 m3_LB0_r 0.304583
RB1_ser_m3 m3_b1 m3_LB1_r 0.304583
RB2_ser_m3 m3_b2 m3_LB2_r 0.304583
RB3_ser_m3 m3_b3 m3_LB3_r 0.304583
RB4_ser_m3 m3_b4 m3_LB4_r 0.304583
RB5_ser_m3 m3_b5 m3_LB5_r 0.304583
RB6_ser_m3 m3_b6 m3_LB6_r 0.304583
RB7_ser_m3 m3_b7 m3_LB7_r 0.304583
RB8_ser_m3 m3_b8 m3_LB8_r 0.304583
RB9_ser_m3 m3_b9 m3_LB9_r 0.304583
RB10_ser_m3 m3_b10 m3_LB10_r 0.304583
RB11_ser_m3 m3_b11 m3_LB11_r 0.304583
RB12_ser_m3 m3_b12 m3_LB12_r 0.304583
RB13_ser_m3 m3_b13 m3_LB13_r 0.304583
RB14_ser_m3 m3_b14 m3_LB14_r 0.304583
RB15_ser_m3 m3_b15 m3_LB15_r 0.304583
RB16_ser_m3 m3_b16 m3_LB16_r 0.304583
RB17_ser_m3 m3_b17 m3_LB17_r 0.304583
RB18_ser_m3 m3_b18 m3_LB18_r 0.304583
RB19_ser_m3 m3_b19 m3_LB19_r 0.304583
RB20_ser_m3 m3_b20 m3_LB20_r 0.304583
RB21_ser_m3 m3_b21 m3_LB21_r 0.304583
RB22_ser_m3 m3_b22 m3_LB22_r 0.304583
RB23_ser_m3 m3_b23 m3_LB23_r 0.304583
RL_m3 m3_out 0 111.6
Cw1_m3 0 m3_b1 1.88877e-12
Cw2_m3 0 m3_b2 6.93669e-13
Cw3_m3 m3_a1 0 1.85791e-12
Cw4_m3 m3_a1 m3_b1 2.30596e-12
Cw5_m3 m3_a1 m3_b2 3.67936e-12
Cw6_m3 m3_a1 m3_b3 5.64837e-13
Cw7_m3 m3_a2 0 6.82719e-13
Cw8_m3 m3_a2 m3_b1 3.61546e-12
Cw9_m3 m3_a2 m3_b2 3.20371e-12
Cw10_m3 m3_a2 m3_b3 3.84678e-12
Cw11_m3 m3_a2 m3_b4 4.87677e-13
Cw12_m3 m3_a3 m3_b1 5.59652e-13
Cw13_m3 m3_a3 m3_b2 3.79446e-12
Cw14_m3 m3_a3 m3_b3 3.6049e-12
Cw15_m3 m3_a3 m3_b4 3.74662e-12
Cw16_m3 m3_a3 m3_b5 4.91093e-13
Cw17_m3 m3_a4 m3_b2 4.82823e-13
Cw18_m3 m3_a4 m3_b3 3.68929e-12
Cw19_m3 m3_a4 m3_b4 3.41257e-12
Cw20_m3 m3_a4 m3_b5 3.82982e-12
Cw21_m3 m3_a4 m3_b6 3.66475e-13
Cw22_m3 m3_a5 m3_b3 4.84656e-13
Cw23_m3 m3_a5 m3_b4 3.76083e-12
Cw24_m3 m3_a5 m3_b5 4.62067e-12
Cw25_m3 m3_a5 m3_b6 3.76912e-12
Cw26_m3 m3_a5 m3_b7 4.56215e-13
Cw27_m3 m3_a6 m3_b4 3.58573e-13
Cw28_m3 m3_a6 m3_b5 3.69298e-12
Cw29_m3 m3_a6 m3_b6 3.40408e-12
Cw30_m3 m3_a6 m3_b7 3.49625e-12
Cw31_m3 m3_a6 m3_b8 4.64291e-13
Cw32_m3 m3_a7 m3_b5 4.42745e-13
Cw33_m3 m3_a7 m3_b6 3.42592e-12
Cw34_m3 m3_a7 m3_b7 3.10999e-12
Cw35_m3 m3_a7 m3_b8 3.55409e-12
Cw36_m3 m3_a7 m3_b9 3.37814e-13
Cw37_m3 m3_a8 m3_b6 4.57264e-13
Cw38_m3 m3_a8 m3_b7 3.48652e-12
Cw39_m3 m3_a8 m3_b8 4.32584e-12
Cw40_m3 m3_a8 m3_b9 3.60162e-12
Cw41_m3 m3_a8 m3_b10 3.27035e-13
Cw42_m3 m3_a9 m3_b7 3.30382e-13
Cw43_m3 m3_a9 m3_b8 3.52602e-12
Cw44_m3 m3_a9 m3_b9 4.2335e-12
Cw45_m3 m3_a9 m3_b10 3.49504e-12
Cw46_m3 m3_a9 m3_b11 2.93097e-13
Cw47_m3 m3_a10 m3_b8 3.18722e-13
Cw48_m3 m3_a10 m3_b9 3.43488e-12
Cw49_m3 m3_a10 m3_b10 4.42498e-12
Cw50_m3 m3_a10 m3_b11 3.47619e-12
Cw51_m3 m3_a10 m3_b12 2.72273e-13
Cw52_m3 m3_a11 m3_b9 2.94605e-13
Cw53_m3 m3_a11 m3_b10 3.42136e-12
Cw54_m3 m3_a11 m3_b11 4.50615e-12
Cw55_m3 m3_a11 m3_b12 3.35002e-12
Cw56_m3 m3_a11 m3_b13 2.64394e-13
Cw57_m3 m3_a12 m3_b10 2.70483e-13
Cw58_m3 m3_a12 m3_b11 3.28198e-12
Cw59_m3 m3_a12 m3_b12 4.39183e-12
Cw60_m3 m3_a12 m3_b13 3.34514e-12
Cw61_m3 m3_a12 m3_b14 1.96051e-13
Cw62_m3 m3_a13 m3_b11 2.58837e-13
Cw63_m3 m3_a13 m3_b12 3.20076e-12
Cw64_m3 m3_a13 m3_b13 4.70579e-12
Cw65_m3 m3_a13 m3_b14 2.57647e-12
Cw66_m3 m3_a13 m3_b15 2.72722e-14
Cw67_m3 m3_a14 m3_b12 2.65476e-13
Cw68_m3 m3_a14 m3_b13 3.80059e-12
Cw69_m3 m3_a14 m3_b14 4.94481e-12
Cw70_m3 m3_a14 m3_b15 2.50803e-12
Cw71_m3 m3_a14 m3_b16 1.43174e-13
Cw72_m3 m3_a15 m3_b13 5.49433e-13
Cw73_m3 m3_a15 m3_b14 3.7498e-12
Cw74_m3 m3_a15 m3_b15 5.3946e-12
Cw75_m3 m3_a15 m3_b16 3.21023e-12
Cw76_m3 m3_a15 m3_b17 1.60886e-13
Cw77_m3 m3_a16 m3_b14 1.96776e-13
Cw78_m3 m3_a16 m3_b15 3.08831e-12
Cw79_m3 m3_a16 m3_b16 5.12854e-12
Cw80_m3 m3_a16 m3_b17 2.92283e-12
Cw81_m3 m3_a16 m3_b18 1.51746e-13
Cw82_m3 m3_a17 m3_b15 1.59607e-13
Cw83_m3 m3_a17 m3_b16 2.87162e-12
Cw84_m3 m3_a17 m3_b17 5.16598e-12
Cw85_m3 m3_a17 m3_b18 3.17711e-12
Cw86_m3 m3_a17 m3_b19 1.4187e-13
Cw87_m3 m3_a18 m3_b16 1.38411e-13
Cw88_m3 m3_a18 m3_b17 2.57579e-12
Cw89_m3 m3_a18 m3_b18 5.0149e-12
Cw90_m3 m3_a18 m3_b19 2.80404e-12
Cw91_m3 m3_a18 m3_b20 7.02574e-14
Cw92_m3 m3_a19 m3_b17 4.3495e-14
Cw93_m3 m3_a19 m3_b18 2.07504e-12
Cw94_m3 m3_a19 m3_b19 6.37706e-12
Cw95_m3 m3_a19 m3_b20 2.71767e-12
Cw96_m3 m3_a19 m3_b21 4.73064e-14
Cw97_m3 m3_a20 m3_b18 5.80409e-14
Cw98_m3 m3_a20 m3_b19 2.63417e-12
Cw99_m3 m3_a20 m3_b20 6.74769e-12
Cw100_m3 m3_a20 m3_b21 2.55805e-12
Cw101_m3 m3_a20 m3_b22 3.58077e-14
Cw102_m3 m3_a21 m3_b19 4.69446e-14
Cw103_m3 m3_a21 m3_b20 2.48631e-12
Cw104_m3 m3_a21 m3_b21 6.80956e-12
Cw105_m3 m3_a21 m3_b22 2.46069e-12
Cw106_m3 m3_a21 m3_b23 2.40394e-14
Cw107_m3 m3_a22 m3_b20 3.38303e-14
Cw108_m3 m3_a22 m3_b21 2.35675e-12
Cw109_m3 m3_a22 m3_b22 6.98178e-12
Cw110_m3 m3_a22 m3_b23 2.31066e-12
Cw111_m3 m3_a22 m3_out 1.26272e-14
Cw112_m3 m3_a23 m3_b21 2.19423e-14
Cw113_m3 m3_a23 m3_b22 2.22041e-12
Cw114_m3 m3_a23 m3_b23 7.24152e-12
Cw115_m3 m3_a23 m3_out 2.11908e-12
Cw116_m3 m3_ac_in m3_b22 1.23273e-14
Cw117_m3 m3_ac_in m3_b23 2.05072e-12
Cw118_m3 m3_ac_in m3_out 2.85249e-12
LAC_m2 m2_LAC_r 0 1.794e-05
LDC_m2 m2_LDC_r 0 1.796e-05
LA0_m3 m3_LA0_r m3_a1 1.63242e-07
LA1_m3 m3_LA1_r m3_a2 1.32612e-07
LA2_m3 m3_LA2_r m3_a3 1.81235e-07
LA3_m3 m3_LA3_r m3_a4 1.41385e-07
LA4_m3 m3_LA4_r m3_a5 1.7146e-07
LA5_m3 m3_LA5_r m3_a6 1.68892e-07
LA6_m3 m3_LA6_r m3_a7 1.28883e-07
LA7_m3 m3_LA7_r m3_a8 1.56308e-07
LA8_m3 m3_LA8_r m3_a9 1.56307e-07
LA9_m3 m3_LA9_r m3_a10 1.46344e-07
LA10_m3 m3_LA10_r m3_a11 1.54943e-07
LA11_m3 m3_LA11_r m3_a12 1.40878e-07
LA12_m3 m3_LA12_r m3_a13 1.44102e-07
LA13_m3 m3_LA13_r m3_a14 1.2313e-07
LA14_m3 m3_LA14_r m3_a15 1.62706e-07
LA15_m3 m3_LA15_r m3_a16 1.48893e-07
LA16_m3 m3_LA16_r m3_a17 1.22067e-07
LA17_m3 m3_LA17_r m3_a18 1.57249e-07
LA18_m3 m3_LA18_r m3_a19 1.37026e-07
LA19_m3 m3_LA19_r m3_a20 1.74699e-07
LA20_m3 m3_LA20_r m3_a21 1.69745e-07
LA21_m3 m3_LA21_r m3_a22 1.69768e-07
LA22_m3 m3_LA22_r m3_a23 1.56275e-07
LA23_m3 m3_LA23_r m3_ac_in 1.39242e-07
LB0_m3 m3_LB0_r m3_b1 1.63084e-07
LB1_m3 m3_LB1_r m3_b2 1.32501e-07
LB2_m3 m3_LB2_r m3_b3 1.81112e-07
LB3_m3 m3_LB3_r m3_b4 1.41406e-07
LB4_m3 m3_LB4_r m3_b5 1.71255e-07
LB5_m3 m3_LB5_r m3_b6 1.68579e-07
LB6_m3 m3_LB6_r m3_b7 1.29137e-07
LB7_m3 m3_LB7_r m3_b8 1.56178e-07
LB8_m3 m3_LB8_r m3_b9 1.56042e-07
LB9_m3 m3_LB9_r m3_b10 1.46867e-07
LB10_m3 m3_LB10_r m3_b11 1.54833e-07
LB11_m3 m3_LB11_r m3_b12 1.40668e-07
LB12_m3 m3_LB12_r m3_b13 1.44102e-07
LB13_m3 m3_LB13_r m3_b14 1.63202e-07
LB14_m3 m3_LB14_r m3_b15 1.20441e-07
LB15_m3 m3_LB15_r m3_b16 1.48801e-07
LB16_m3 m3_LB16_r m3_b17 1.22166e-07
LB17_m3 m3_LB17_r m3_b18 1.35704e-07
LB18_m3 m3_LB18_r m3_b19 1.57396e-07
LB19_m3 m3_LB19_r m3_b20 1.76325e-07
LB20_m3 m3_LB20_r m3_b21 1.69108e-07
LB21_m3 m3_LB21_r m3_b22 1.6907e-07
LB22_m3 m3_LB22_r m3_b23 1.57145e-07
LB23_m3 m3_LB23_r m3_out 1.39268e-07
K1 LAC_m2 LDC_m2 0.909259194
K2 LA0_m3 LA1_m3 0.019398625
K3 LA0_m3 LA2_m3 0.422736828
K4 LA0_m3 LA3_m3 0.287895155
K5 LA0_m3 LA4_m3 0.126677801
K6 LA0_m3 LA5_m3 0.287049687
K7 LA0_m3 LA6_m3 0.222466727
K8 LA0_m3 LA7_m3 0.079408835
K9 LA0_m3 LA8_m3 0.222352328
K10 LA0_m3 LA9_m3 0.232362816
K11 LA0_m3 LA10_m3 0.097868827
K12 LA0_m3 LA11_m3 0.059446128
K13 LA0_m3 LA12_m3 0.151947585
K14 LA0_m3 LA13_m3 0.193809474
K15 LA0_m3 LA14_m3 0.113716054
K16 LA0_m3 LA15_m3 0.101082101
K17 LA0_m3 LA16_m3 0.059174594
K18 LA0_m3 LA17_m3 0.093703977
K19 LA0_m3 LA18_m3 0.068717077
K20 LA0_m3 LA19_m3 0.011515180
K21 LA0_m3 LA20_m3 0.082257528
K22 LA0_m3 LA21_m3 0.008678379
K23 LA0_m3 LA22_m3 0.038394779
K24 LA0_m3 LA23_m3 0.042519490
K25 LA0_m3 LB0_m3 0.078445084
K26 LA0_m3 LB1_m3 0.606900367
K27 LA0_m3 LB2_m3 0.197966683
K28 LA0_m3 LB3_m3 0.176835388
K29 LA0_m3 LB4_m3 0.357096927
K30 LA0_m3 LB5_m3 0.138747620
K31 LA0_m3 LB6_m3 0.112860737
K32 LA0_m3 LB7_m3 0.279377302
K33 LA0_m3 LB8_m3 0.106443702
K34 LA0_m3 LB9_m3 0.064973856
K35 LA0_m3 LB10_m3 0.192826778
K36 LA0_m3 LB11_m3 0.199141159
K37 LA0_m3 LB12_m3 0.089037895
K38 LA0_m3 LB13_m3 0.110729886
K39 LA0_m3 LB14_m3 0.027859607
K40 LA0_m3 LB15_m3 0.099829295
K41 LA0_m3 LB16_m3 0.107140897
K42 LA0_m3 LB17_m3 0.082675753
K43 LA0_m3 LB18_m3 0.063660895
K44 LA0_m3 LB19_m3 0.102378256
K45 LA0_m3 LB20_m3 0.017419692
K46 LA0_m3 LB21_m3 0.070147279
K47 LA0_m3 LB22_m3 0.019321430
K48 LA0_m3 LB23_m3 -0.010376324
K49 LA1_m3 LA2_m3 0.191567953
K50 LA1_m3 LA3_m3 0.254015658
K51 LA1_m3 LA4_m3 0.378805916
K52 LA1_m3 LA5_m3 0.126010014
K53 LA1_m3 LA6_m3 0.157897724
K54 LA1_m3 LA7_m3 0.287008099
K55 LA1_m3 LA8_m3 0.094452147
K56 LA1_m3 LA9_m3 0.084569998
K57 LA1_m3 LA10_m3 0.213163170
K58 LA1_m3 LA11_m3 0.199989761
K59 LA1_m3 LA12_m3 0.081537264
K60 LA1_m3 LA13_m3 0.029470063
K61 LA1_m3 LA14_m3 0.122133266
K62 LA1_m3 LA15_m3 0.107684116
K63 LA1_m3 LA16_m3 0.119860835
K64 LA1_m3 LA17_m3 0.073118428
K65 LA1_m3 LA18_m3 0.068237917
K66 LA1_m3 LA19_m3 0.103492830
K67 LA1_m3 LA20_m3 0.026351962
K68 LA1_m3 LA21_m3 0.067745326
K69 LA1_m3 LA22_m3 0.018608292
K70 LA1_m3 LA23_m3 -0.006224559
K71 LA1_m3 LB0_m3 0.610820016
K72 LA1_m3 LB1_m3 -0.031377115
K73 LA1_m3 LB2_m3 0.534122189
K74 LA1_m3 LB3_m3 0.258978308
K75 LA1_m3 LB4_m3 0.131514070
K76 LA1_m3 LB5_m3 0.320804223
K77 LA1_m3 LB6_m3 0.190560580
K78 LA1_m3 LB7_m3 0.081169501
K79 LA1_m3 LB8_m3 0.242526519
K80 LA1_m3 LB9_m3 0.216326070
K81 LA1_m3 LB10_m3 0.083343297
K82 LA1_m3 LB11_m3 0.064637581
K83 LA1_m3 LB12_m3 0.163856171
K84 LA1_m3 LB13_m3 0.131221531
K85 LA1_m3 LB14_m3 0.156328956
K86 LA1_m3 LB15_m3 0.096714868
K87 LA1_m3 LB16_m3 0.049818742
K88 LA1_m3 LB17_m3 0.080665541
K89 LA1_m3 LB18_m3 0.087691241
K90 LA1_m3 LB19_m3 0.014787116
K91 LA1_m3 LB20_m3 0.071096504
K92 LA1_m3 LB21_m3 0.015003047
K93 LA1_m3 LB22_m3 0.037395753
K94 LA1_m3 LB23_m3 0.036260072
K95 LA2_m3 LA3_m3 0.233930175
K96 LA2_m3 LA4_m3 0.335468189
K97 LA2_m3 LA5_m3 0.431863212
K98 LA2_m3 LA6_m3 0.153530241
K99 LA2_m3 LA7_m3 0.224762184
K100 LA2_m3 LA8_m3 0.316941862
K101 LA2_m3 LA9_m3 0.173884609
K102 LA2_m3 LA10_m3 0.167703329
K103 LA2_m3 LA11_m3 0.166589205
K104 LA2_m3 LA12_m3 0.219501647
K105 LA2_m3 LA13_m3 0.132468565
K106 LA2_m3 LA14_m3 0.154843765
K107 LA2_m3 LA15_m3 0.134342390
K108 LA2_m3 LA16_m3 0.094212478
K109 LA2_m3 LA17_m3 0.122181133
K110 LA2_m3 LA18_m3 0.101807688
K111 LA2_m3 LA19_m3 0.076769471
K112 LA2_m3 LA20_m3 0.057000172
K113 LA2_m3 LA21_m3 0.058015117
K114 LA2_m3 LA22_m3 0.044727518
K115 LA2_m3 LA23_m3 0.017712169
K116 LA2_m3 LB0_m3 0.196952006
K117 LA2_m3 LB1_m3 0.532906355
K118 LA2_m3 LB2_m3 0.381649756
K119 LA2_m3 LB3_m3 0.503882970
K120 LA2_m3 LB4_m3 0.317273020
K121 LA2_m3 LB5_m3 0.250447477
K122 LA2_m3 LB6_m3 0.306059031
K123 LA2_m3 LB7_m3 0.223652558
K124 LA2_m3 LB8_m3 0.179785842
K125 LA2_m3 LB9_m3 0.194715179
K126 LA2_m3 LB10_m3 0.250229949
K127 LA2_m3 LB11_m3 0.151414513
K128 LA2_m3 LB12_m3 0.133200212
K129 LA2_m3 LB13_m3 0.158040656
K130 LA2_m3 LB14_m3 0.119300769
K131 LA2_m3 LB15_m3 0.137716481
K132 LA2_m3 LB16_m3 0.143300760
K133 LA2_m3 LB17_m3 0.106795119
K134 LA2_m3 LB18_m3 0.070033986
K135 LA2_m3 LB19_m3 0.084799775
K136 LA2_m3 LB20_m3 0.074282003
K137 LA2_m3 LB21_m3 0.047192081
K138 LA2_m3 LB22_m3 0.033971082
K139 LA2_m3 LB23_m3 0.023075625
K140 LA3_m3 LA4_m3 0.193720316
K141 LA3_m3 LA5_m3 0.234451137
K142 LA3_m3 LA6_m3 0.451182501
K143 LA3_m3 LA7_m3 0.112703205
K144 LA3_m3 LA8_m3 0.152511591
K145 LA3_m3 LA9_m3 0.299767941
K146 LA3_m3 LA10_m3 0.207874348
K147 LA3_m3 LA11_m3 0.073341701
K148 LA3_m3 LA12_m3 0.104366229
K149 LA3_m3 LA13_m3 0.209146040
K150 LA3_m3 LA14_m3 0.136897404
K151 LA3_m3 LA15_m3 0.125808713
K152 LA3_m3 LA16_m3 0.122734395
K153 LA3_m3 LA17_m3 0.083411975
K154 LA3_m3 LA18_m3 0.059336259
K155 LA3_m3 LA19_m3 0.030814474
K156 LA3_m3 LA20_m3 0.106590665
K157 LA3_m3 LA21_m3 0.006880385
K158 LA3_m3 LA22_m3 0.032550033
K159 LA3_m3 LA23_m3 0.049871645
K160 LA3_m3 LB0_m3 0.179312593
K161 LA3_m3 LB1_m3 0.257810863
K162 LA3_m3 LB2_m3 0.505344216
K163 LA3_m3 LB3_m3 0.070731013
K164 LA3_m3 LB4_m3 0.526463971
K165 LA3_m3 LB5_m3 0.364936660
K166 LA3_m3 LB6_m3 0.022888503
K167 LA3_m3 LB7_m3 0.326879123
K168 LA3_m3 LB8_m3 0.258361253
K169 LA3_m3 LB9_m3 0.075944871
K170 LA3_m3 LB10_m3 0.138492670
K171 LA3_m3 LB11_m3 0.234913942
K172 LA3_m3 LB12_m3 0.185629388
K173 LA3_m3 LB13_m3 0.132189628
K174 LA3_m3 LB14_m3 0.036152573
K175 LA3_m3 LB15_m3 0.110107435
K176 LA3_m3 LB16_m3 0.071330614
K177 LA3_m3 LB17_m3 0.096339928
K178 LA3_m3 LB18_m3 0.109475102
K179 LA3_m3 LB19_m3 0.102235794
K180 LA3_m3 LB20_m3 0.005175050
K181 LA3_m3 LB21_m3 0.084322737
K182 LA3_m3 LB22_m3 0.030405822
K183 LA3_m3 LB23_m3 -0.014036107
K184 LA4_m3 LA5_m3 0.336039429
K185 LA4_m3 LA6_m3 0.186980162
K186 LA4_m3 LA7_m3 0.438184619
K187 LA4_m3 LA8_m3 0.221401730
K188 LA4_m3 LA9_m3 0.153418255
K189 LA4_m3 LA10_m3 0.226984929
K190 LA4_m3 LA11_m3 0.281707430
K191 LA4_m3 LA12_m3 0.160028546
K192 LA4_m3 LA13_m3 0.080533834
K193 LA4_m3 LA14_m3 0.164922535
K194 LA4_m3 LA15_m3 0.140637379
K195 LA4_m3 LA16_m3 0.115336500
K196 LA4_m3 LA17_m3 0.118919633
K197 LA4_m3 LA18_m3 0.104182574
K198 LA4_m3 LA19_m3 0.116292416
K199 LA4_m3 LA20_m3 0.029472920
K200 LA4_m3 LA21_m3 0.087768666
K201 LA4_m3 LA22_m3 0.031253012
K202 LA4_m3 LA23_m3 -0.005870856
K203 LA4_m3 LB0_m3 0.356972864
K204 LA4_m3 LB1_m3 0.131327119
K205 LA4_m3 LB2_m3 0.317756648
K206 LA4_m3 LB3_m3 0.526572381
K207 LA4_m3 LB4_m3 0.331772133
K208 LA4_m3 LB5_m3 0.437859292
K209 LA4_m3 LB6_m3 0.389354803
K210 LA4_m3 LB7_m3 0.199049485
K211 LA4_m3 LB8_m3 0.255914892
K212 LA4_m3 LB9_m3 0.323329597
K213 LA4_m3 LB10_m3 0.176162752
K214 LA4_m3 LB11_m3 0.124142151
K215 LA4_m3 LB12_m3 0.161413812
K216 LA4_m3 LB13_m3 0.180065551
K217 LA4_m3 LB14_m3 0.210652999
K218 LA4_m3 LB15_m3 0.136615200
K219 LA4_m3 LB16_m3 0.098209899
K220 LA4_m3 LB17_m3 0.108509623
K221 LA4_m3 LB18_m3 0.095086040
K222 LA4_m3 LB19_m3 0.033128379
K223 LA4_m3 LB20_m3 0.098295305
K224 LA4_m3 LB21_m3 0.021588870
K225 LA4_m3 LB22_m3 0.040973660
K226 LA4_m3 LB23_m3 0.045643062
K227 LA5_m3 LA6_m3 0.236037757
K228 LA5_m3 LA7_m3 0.334964624
K229 LA5_m3 LA8_m3 0.424452413
K230 LA5_m3 LA9_m3 0.223532850
K231 LA5_m3 LA10_m3 0.218954830
K232 LA5_m3 LA11_m3 0.206743721
K233 LA5_m3 LA12_m3 0.265741280
K234 LA5_m3 LA13_m3 0.158961791
K235 LA5_m3 LA14_m3 0.185940927
K236 LA5_m3 LA15_m3 0.160135433
K237 LA5_m3 LA16_m3 0.114466042
K238 LA5_m3 LA17_m3 0.141877851
K239 LA5_m3 LA18_m3 0.117162565
K240 LA5_m3 LA19_m3 0.089783143
K241 LA5_m3 LA20_m3 0.067006408
K242 LA5_m3 LA21_m3 0.066082989
K243 LA5_m3 LA22_m3 0.050787682
K244 LA5_m3 LA23_m3 0.020653479
K245 LA5_m3 LB0_m3 0.138428873
K246 LA5_m3 LB1_m3 0.319701430
K247 LA5_m3 LB2_m3 0.250402385
K248 LA5_m3 LB3_m3 0.366277778
K249 LA5_m3 LB4_m3 0.436795688
K250 LA5_m3 LB5_m3 0.392583440
K251 LA5_m3 LB6_m3 0.501321084
K252 LA5_m3 LB7_m3 0.312296007
K253 LA5_m3 LB8_m3 0.254305632
K254 LA5_m3 LB9_m3 0.254051923
K255 LA5_m3 LB10_m3 0.313574729
K256 LA5_m3 LB11_m3 0.186136581
K257 LA5_m3 LB12_m3 0.168094311
K258 LA5_m3 LB13_m3 0.191906424
K259 LA5_m3 LB14_m3 0.142220653
K260 LA5_m3 LB15_m3 0.163526249
K261 LA5_m3 LB16_m3 0.166732718
K262 LA5_m3 LB17_m3 0.125250485
K263 LA5_m3 LB18_m3 0.083357320
K264 LA5_m3 LB19_m3 0.097888544
K265 LA5_m3 LB20_m3 0.084629471
K266 LA5_m3 LB21_m3 0.054726587
K267 LA5_m3 LB22_m3 0.039550998
K268 LA5_m3 LB23_m3 0.025982083
K269 LA6_m3 LA7_m3 0.180723535
K270 LA6_m3 LA8_m3 0.234406949
K271 LA6_m3 LA9_m3 0.393149984
K272 LA6_m3 LA10_m3 0.264939513
K273 LA6_m3 LA11_m3 0.096941111
K274 LA6_m3 LA12_m3 0.133640868
K275 LA6_m3 LA13_m3 0.248526688
K276 LA6_m3 LA14_m3 0.164061731
K277 LA6_m3 LA15_m3 0.148590933
K278 LA6_m3 LA16_m3 0.142668821
K279 LA6_m3 LA17_m3 0.097955177
K280 LA6_m3 LA18_m3 0.069859985
K281 LA6_m3 LA19_m3 0.037339472
K282 LA6_m3 LA20_m3 0.119153619
K283 LA6_m3 LA21_m3 0.009874294
K284 LA6_m3 LA22_m3 0.037237494
K285 LA6_m3 LA23_m3 0.054774557
K286 LA6_m3 LB0_m3 0.113518563
K287 LA6_m3 LB1_m3 0.190033606
K288 LA6_m3 LB2_m3 0.305807747
K289 LA6_m3 LB3_m3 0.022125698
K290 LA6_m3 LB4_m3 0.389662348
K291 LA6_m3 LB5_m3 0.500398334
K292 LA6_m3 LB6_m3 0.058611207
K293 LA6_m3 LB7_m3 0.528548025
K294 LA6_m3 LB8_m3 0.357693860
K295 LA6_m3 LB9_m3 0.110579049
K296 LA6_m3 LB10_m3 0.183692804
K297 LA6_m3 LB11_m3 0.289710217
K298 LA6_m3 LB12_m3 0.225373327
K299 LA6_m3 LB13_m3 0.160030817
K300 LA6_m3 LB14_m3 0.047153364
K301 LA6_m3 LB15_m3 0.131364198
K302 LA6_m3 LB16_m3 0.086180147
K303 LA6_m3 LB17_m3 0.112622997
K304 LA6_m3 LB18_m3 0.124683144
K305 LA6_m3 LB19_m3 0.115862648
K306 LA6_m3 LB20_m3 0.008792259
K307 LA6_m3 LB21_m3 0.093848977
K308 LA6_m3 LB22_m3 0.034487017
K309 LA6_m3 LB23_m3 -0.014283235
K310 LA7_m3 LA8_m3 0.333281438
K311 LA7_m3 LA9_m3 0.236322926
K312 LA7_m3 LA10_m3 0.304816141
K313 LA7_m3 LA11_m3 0.355958995
K314 LA7_m3 LA12_m3 0.200173999
K315 LA7_m3 LA13_m3 0.106345086
K316 LA7_m3 LA14_m3 0.201114996
K317 LA7_m3 LA15_m3 0.169401370
K318 LA7_m3 LA16_m3 0.136684547
K319 LA7_m3 LA17_m3 0.140367142
K320 LA7_m3 LA18_m3 0.120514686
K321 LA7_m3 LA19_m3 0.132135919
K322 LA7_m3 LA20_m3 0.035871706
K323 LA7_m3 LA21_m3 0.098569595
K324 LA7_m3 LA22_m3 0.036007002
K325 LA7_m3 LA23_m3 -0.005334617
K326 LA7_m3 LB0_m3 0.279258139
K327 LA7_m3 LB1_m3 0.081292069
K328 LA7_m3 LB2_m3 0.224043347
K329 LA7_m3 LB3_m3 0.327097912
K330 LA7_m3 LB4_m3 0.199042951
K331 LA7_m3 LB5_m3 0.313431293
K332 LA7_m3 LB6_m3 0.528217470
K333 LA7_m3 LB7_m3 0.318642798
K334 LA7_m3 LB8_m3 0.431816469
K335 LA7_m3 LB9_m3 0.444529073
K336 LA7_m3 LB10_m3 0.236074500
K337 LA7_m3 LB11_m3 0.167440796
K338 LA7_m3 LB12_m3 0.204378184
K339 LA7_m3 LB13_m3 0.222041959
K340 LA7_m3 LB14_m3 0.250395164
K341 LA7_m3 LB15_m3 0.163402874
K342 LA7_m3 LB16_m3 0.117217127
K343 LA7_m3 LB17_m3 0.127875168
K344 LA7_m3 LB18_m3 0.110620967
K345 LA7_m3 LB19_m3 0.040840790
K346 LA7_m3 LB20_m3 0.111126978
K347 LA7_m3 LB21_m3 0.026357505
K348 LA7_m3 LB22_m3 0.046383981
K349 LA7_m3 LB23_m3 0.050497713
K350 LA8_m3 LA9_m3 0.335506555
K351 LA8_m3 LA10_m3 0.325891000
K352 LA8_m3 LA11_m3 0.279956927
K353 LA8_m3 LA12_m3 0.341456683
K354 LA8_m3 LA13_m3 0.198571334
K355 LA8_m3 LA14_m3 0.231742332
K356 LA8_m3 LA15_m3 0.196666685
K357 LA8_m3 LA16_m3 0.142342480
K358 LA8_m3 LA17_m3 0.168479774
K359 LA8_m3 LA18_m3 0.137351399
K360 LA8_m3 LA19_m3 0.106886429
K361 LA8_m3 LA20_m3 0.079640785
K362 LA8_m3 LA21_m3 0.076421328
K363 LA8_m3 LA22_m3 0.058390868
K364 LA8_m3 LA23_m3 0.024210706
K365 LA8_m3 LB0_m3 0.106021703
K366 LA8_m3 LB1_m3 0.241762411
K367 LA8_m3 LB2_m3 0.179814551
K368 LA8_m3 LB3_m3 0.258922732
K369 LA8_m3 LB4_m3 0.255137210
K370 LA8_m3 LB5_m3 0.254168264
K371 LA8_m3 LB6_m3 0.358598915
K372 LA8_m3 LB7_m3 0.431076100
K373 LA8_m3 LB8_m3 0.402145743
K374 LA8_m3 LB9_m3 0.430239810
K375 LA8_m3 LB10_m3 0.440840362
K376 LA8_m3 LB11_m3 0.244514739
K377 LA8_m3 LB12_m3 0.224909096
K378 LA8_m3 LB13_m3 0.244014505
K379 LA8_m3 LB14_m3 0.176182405
K380 LA8_m3 LB15_m3 0.200220784
K381 LA8_m3 LB16_m3 0.199094653
K382 LA8_m3 LB17_m3 0.150079303
K383 LA8_m3 LB18_m3 0.100741982
K384 LA8_m3 LB19_m3 0.114725735
K385 LA8_m3 LB20_m3 0.098044192
K386 LA8_m3 LB21_m3 0.064105892
K387 LA8_m3 LB22_m3 0.046597674
K388 LA8_m3 LB23_m3 0.029714674
K389 LA9_m3 LA10_m3 0.351481714
K390 LA9_m3 LA11_m3 0.241147247
K391 LA9_m3 LA12_m3 0.259848203
K392 LA9_m3 LA13_m3 0.351044061
K393 LA9_m3 LA14_m3 0.233921300
K394 LA9_m3 LA15_m3 0.202771155
K395 LA9_m3 LA16_m3 0.148834416
K396 LA9_m3 LA17_m3 0.157806883
K397 LA9_m3 LA18_m3 0.112223674
K398 LA9_m3 LA19_m3 0.054925782
K399 LA9_m3 LA20_m3 0.129569690
K400 LA9_m3 LA21_m3 0.032291122
K401 LA9_m3 LA22_m3 0.051369454
K402 LA9_m3 LA23_m3 0.057393751
K403 LA9_m3 LB0_m3 0.064284262
K404 LA9_m3 LB1_m3 0.215526930
K405 LA9_m3 LB2_m3 0.194761075
K406 LA9_m3 LB3_m3 0.074551023
K407 LA9_m3 LB4_m3 0.323477303
K408 LA9_m3 LB5_m3 0.253657019
K409 LA9_m3 LB6_m3 0.109280939
K410 LA9_m3 LB7_m3 0.444734649
K411 LA9_m3 LB8_m3 0.429354491
K412 LA9_m3 LB9_m3 0.317665843
K413 LA9_m3 LB10_m3 0.421070246
K414 LA9_m3 LB11_m3 0.448519995
K415 LA9_m3 LB12_m3 0.257435704
K416 LA9_m3 LB13_m3 0.243975559
K417 LA9_m3 LB14_m3 0.120273256
K418 LA9_m3 LB15_m3 0.192436061
K419 LA9_m3 LB16_m3 0.146233248
K420 LA9_m3 LB17_m3 0.153655360
K421 LA9_m3 LB18_m3 0.144312959
K422 LA9_m3 LB19_m3 0.141517496
K423 LA9_m3 LB20_m3 0.037847184
K424 LA9_m3 LB21_m3 0.106017221
K425 LA9_m3 LB22_m3 0.040293087
K426 LA9_m3 LB23_m3 -0.004873551
K427 LA10_m3 LA11_m3 0.376983358
K428 LA10_m3 LA12_m3 0.334340885
K429 LA10_m3 LA13_m3 0.254268379
K430 LA10_m3 LA14_m3 0.297915007
K431 LA10_m3 LA15_m3 0.251075688
K432 LA10_m3 LA16_m3 0.241488585
K433 LA10_m3 LA17_m3 0.169067683
K434 LA10_m3 LA18_m3 0.141114723
K435 LA10_m3 LA19_m3 0.140290160
K436 LA10_m3 LA20_m3 0.111731607
K437 LA10_m3 LA21_m3 0.081589417
K438 LA10_m3 LA22_m3 0.055782498
K439 LA10_m3 LA23_m3 0.031597734
K440 LA10_m3 LB0_m3 0.194085380
K441 LA10_m3 LB1_m3 0.083417247
K442 LA10_m3 LB2_m3 0.250060794
K443 LA10_m3 LB3_m3 0.139636347
K444 LA10_m3 LB4_m3 0.176211710
K445 LA10_m3 LB5_m3 0.313531284
K446 LA10_m3 LB6_m3 0.185154942
K447 LA10_m3 LB7_m3 0.236298012
K448 LA10_m3 LB8_m3 0.440560694
K449 LA10_m3 LB9_m3 0.423234236
K450 LA10_m3 LB10_m3 0.455528260
K451 LA10_m3 LB11_m3 0.420468178
K452 LA10_m3 LB12_m3 0.427796390
K453 LA10_m3 LB13_m3 0.319310923
K454 LA10_m3 LB14_m3 0.212743212
K455 LA10_m3 LB15_m3 0.233145529
K456 LA10_m3 LB16_m3 0.171803992
K457 LA10_m3 LB17_m3 0.181637478
K458 LA10_m3 LB18_m3 0.167461249
K459 LA10_m3 LB19_m3 0.117368083
K460 LA10_m3 LB20_m3 0.095402622
K461 LA10_m3 LB21_m3 0.080966803
K462 LA10_m3 LB22_m3 0.063459042
K463 LA10_m3 LB23_m3 0.030113520
K464 LA11_m3 LA12_m3 0.373067942
K465 LA11_m3 LA13_m3 0.222291770
K466 LA11_m3 LA14_m3 0.315724942
K467 LA11_m3 LA15_m3 0.252439886
K468 LA11_m3 LA16_m3 0.190811218
K469 LA11_m3 LA17_m3 0.197574613
K470 LA11_m3 LA18_m3 0.158761747
K471 LA11_m3 LA19_m3 0.162504469
K472 LA11_m3 LA20_m3 0.055660731
K473 LA11_m3 LA21_m3 0.118611915
K474 LA11_m3 LA22_m3 0.048189930
K475 LA11_m3 LA23_m3 0.000030486
K476 LA11_m3 LB0_m3 0.198582473
K477 LA11_m3 LB1_m3 0.065026098
K478 LA11_m3 LB2_m3 0.151794686
K479 LA11_m3 LB3_m3 0.234640184
K480 LA11_m3 LB4_m3 0.124470994
K481 LA11_m3 LB5_m3 0.186870886
K482 LA11_m3 LB6_m3 0.289134089
K483 LA11_m3 LB7_m3 0.168009197
K484 LA11_m3 LB8_m3 0.245185809
K485 LA11_m3 LB9_m3 0.448116961
K486 LA11_m3 LB10_m3 0.421494599
K487 LA11_m3 LB11_m3 0.359866079
K488 LA11_m3 LB12_m3 0.417957790
K489 LA11_m3 LB13_m3 0.363269370
K490 LA11_m3 LB14_m3 0.361228109
K491 LA11_m3 LB15_m3 0.240250296
K492 LA11_m3 LB16_m3 0.172748472
K493 LA11_m3 LB17_m3 0.178324294
K494 LA11_m3 LB18_m3 0.146723128
K495 LA11_m3 LB19_m3 0.067610651
K496 LA11_m3 LB20_m3 0.135604548
K497 LA11_m3 LB21_m3 0.042510133
K498 LA11_m3 LB22_m3 0.057037601
K499 LA11_m3 LB23_m3 0.057363172
K500 LA12_m3 LA13_m3 0.344203253
K501 LA12_m3 LA14_m3 0.397764437
K502 LA12_m3 LA15_m3 0.309179973
K503 LA12_m3 LA16_m3 0.224402921
K504 LA12_m3 LA17_m3 0.237060492
K505 LA12_m3 LA18_m3 0.185751010
K506 LA12_m3 LA19_m3 0.152398065
K507 LA12_m3 LA20_m3 0.106400483
K508 LA12_m3 LA21_m3 0.102555728
K509 LA12_m3 LA22_m3 0.073825751
K510 LA12_m3 LA23_m3 0.030055345
K511 LA12_m3 LB0_m3 0.088548571
K512 LA12_m3 LB1_m3 0.163560919
K513 LA12_m3 LB2_m3 0.133131732
K514 LA12_m3 LB3_m3 0.185830352
K515 LA12_m3 LB4_m3 0.161127172
K516 LA12_m3 LB5_m3 0.167931142
K517 LA12_m3 LB6_m3 0.225661334
K518 LA12_m3 LB7_m3 0.204134418
K519 LA12_m3 LB8_m3 0.224667606
K520 LA12_m3 LB9_m3 0.257541546
K521 LA12_m3 LB10_m3 0.428365770
K522 LA12_m3 LB11_m3 0.417136176
K523 LA12_m3 LB12_m3 0.461322444
K524 LA12_m3 LB13_m3 0.486794825
K525 LA12_m3 LB14_m3 0.304745939
K526 LA12_m3 LB15_m3 0.310840747
K527 LA12_m3 LB16_m3 0.283245932
K528 LA12_m3 LB17_m3 0.214620236
K529 LA12_m3 LB18_m3 0.145893368
K530 LA12_m3 LB19_m3 0.150027554
K531 LA12_m3 LB20_m3 0.130532845
K532 LA12_m3 LB21_m3 0.083535983
K533 LA12_m3 LB22_m3 0.063209387
K534 LA12_m3 LB23_m3 0.039856889
K535 LA13_m3 LA14_m3 0.417075508
K536 LA13_m3 LA15_m3 0.313953841
K537 LA13_m3 LA16_m3 0.212967414
K538 LA13_m3 LA17_m3 0.229516341
K539 LA13_m3 LA18_m3 0.158680969
K540 LA13_m3 LA19_m3 0.074921891
K541 LA13_m3 LA20_m3 0.163696578
K542 LA13_m3 LA21_m3 0.045533770
K543 LA13_m3 LA22_m3 0.067037121
K544 LA13_m3 LA23_m3 0.069256150
K545 LA13_m3 LB0_m3 0.021743356
K546 LA13_m3 LB1_m3 0.178864512
K547 LA13_m3 LB2_m3 0.123672989
K548 LA13_m3 LB3_m3 0.036807255
K549 LA13_m3 LB4_m3 0.238190760
K550 LA13_m3 LB5_m3 0.149731086
K551 LA13_m3 LB6_m3 0.049541515
K552 LA13_m3 LB7_m3 0.287874344
K553 LA13_m3 LB8_m3 0.191151773
K554 LA13_m3 LB9_m3 0.133970897
K555 LA13_m3 LB10_m3 0.254556637
K556 LA13_m3 LB11_m3 0.441741850
K557 LA13_m3 LB12_m3 0.415051760
K558 LA13_m3 LB13_m3 0.483905871
K559 LA13_m3 LB14_m3 0.253929641
K560 LA13_m3 LB15_m3 0.317270194
K561 LA13_m3 LB16_m3 0.230634503
K562 LA13_m3 LB17_m3 0.222177424
K563 LA13_m3 LB18_m3 0.191765998
K564 LA13_m3 LB19_m3 0.185508733
K565 LA13_m3 LB20_m3 0.057343427
K566 LA13_m3 LB21_m3 0.131303080
K567 LA13_m3 LB22_m3 0.051021402
K568 LA13_m3 LB23_m3 -0.003029958
K569 LA14_m3 LA15_m3 0.503371223
K570 LA14_m3 LA16_m3 0.353962203
K571 LA14_m3 LA17_m3 0.320846135
K572 LA14_m3 LA18_m3 0.235390550
K573 LA14_m3 LA19_m3 0.192486620
K574 LA14_m3 LA20_m3 0.156588533
K575 LA14_m3 LA21_m3 0.121356978
K576 LA14_m3 LA22_m3 0.085264887
K577 LA14_m3 LA23_m3 0.045554079
K578 LA14_m3 LB0_m3 0.115558606
K579 LA14_m3 LB1_m3 0.109868784
K580 LA14_m3 LB2_m3 0.153342221
K581 LA14_m3 LB3_m3 0.131395013
K582 LA14_m3 LB4_m3 0.154517865
K583 LA14_m3 LB5_m3 0.184070867
K584 LA14_m3 LB6_m3 0.158082887
K585 LA14_m3 LB7_m3 0.187598503
K586 LA14_m3 LB8_m3 0.229379093
K587 LA14_m3 LB9_m3 0.232350865
K588 LA14_m3 LB10_m3 0.280510702
K589 LA14_m3 LB11_m3 0.290516871
K590 LA14_m3 LB12_m3 0.388873524
K591 LA14_m3 LB13_m3 0.571707510
K592 LA14_m3 LB14_m3 0.510738741
K593 LA14_m3 LB15_m3 0.512459717
K594 LA14_m3 LB16_m3 0.350907941
K595 LA14_m3 LB17_m3 0.308452050
K596 LA14_m3 LB18_m3 0.241548588
K597 LA14_m3 LB19_m3 0.189099804
K598 LA14_m3 LB20_m3 0.148076213
K599 LA14_m3 LB21_m3 0.119018554
K600 LA14_m3 LB22_m3 0.082120991
K601 LA14_m3 LB23_m3 0.042500604
K602 LA15_m3 LA16_m3 0.461866780
K603 LA15_m3 LA17_m3 0.393221251
K604 LA15_m3 LA18_m3 0.271751993
K605 LA15_m3 LA19_m3 0.219390205
K606 LA15_m3 LA20_m3 0.179232592
K607 LA15_m3 LA21_m3 0.133345046
K608 LA15_m3 LA22_m3 0.094694500
K609 LA15_m3 LA23_m3 0.051724700
K610 LA15_m3 LB0_m3 0.099799200
K611 LA15_m3 LB1_m3 0.096640283
K612 LA15_m3 LB2_m3 0.137769439
K613 LA15_m3 LB3_m3 0.110061621
K614 LA15_m3 LB4_m3 0.136714595
K615 LA15_m3 LB5_m3 0.163568838
K616 LA15_m3 LB6_m3 0.131334705
K617 LA15_m3 LB7_m3 0.163598544
K618 LA15_m3 LB8_m3 0.200221333
K619 LA15_m3 LB9_m3 0.192472330
K620 LA15_m3 LB10_m3 0.233026449
K621 LA15_m3 LB11_m3 0.240409850
K622 LA15_m3 LB12_m3 0.311001168
K623 LA15_m3 LB13_m3 0.398785317
K624 LA15_m3 LB14_m3 0.450031989
K625 LA15_m3 LB15_m3 0.599692598
K626 LA15_m3 LB16_m3 0.481521971
K627 LA15_m3 LB17_m3 0.380059819
K628 LA15_m3 LB18_m3 0.284458222
K629 LA15_m3 LB19_m3 0.218911201
K630 LA15_m3 LB20_m3 0.164420325
K631 LA15_m3 LB21_m3 0.134710534
K632 LA15_m3 LB22_m3 0.091157562
K633 LA15_m3 LB23_m3 0.045390191
K634 LA16_m3 LA17_m3 0.421929638
K635 LA16_m3 LA18_m3 0.285106308
K636 LA16_m3 LA19_m3 0.252792899
K637 LA16_m3 LA20_m3 0.200353517
K638 LA16_m3 LA21_m3 0.133976027
K639 LA16_m3 LA22_m3 0.096551039
K640 LA16_m3 LA23_m3 0.054607707
K641 LA16_m3 LB0_m3 0.107593177
K642 LA16_m3 LB1_m3 0.049873790
K643 LA16_m3 LB2_m3 0.143395227
K644 LA16_m3 LB3_m3 0.071375436
K645 LA16_m3 LB4_m3 0.098400477
K646 LA16_m3 LB5_m3 0.166862105
K647 LA16_m3 LB6_m3 0.086305978
K648 LA16_m3 LB7_m3 0.117485710
K649 LA16_m3 LB8_m3 0.199187493
K650 LA16_m3 LB9_m3 0.146507570
K651 LA16_m3 LB10_m3 0.171792464
K652 LA16_m3 LB11_m3 0.172965301
K653 LA16_m3 LB12_m3 0.283471529
K654 LA16_m3 LB13_m3 0.303794701
K655 LA16_m3 LB14_m3 0.287453380
K656 LA16_m3 LB15_m3 0.482241061
K657 LA16_m3 LB16_m3 0.482448984
K658 LA16_m3 LB17_m3 0.480528803
K659 LA16_m3 LB18_m3 0.334815513
K660 LA16_m3 LB19_m3 0.235397145
K661 LA16_m3 LB20_m3 0.165831026
K662 LA16_m3 LB21_m3 0.141399679
K663 LA16_m3 LB22_m3 0.102236658
K664 LA16_m3 LB23_m3 0.045610397
K665 LA17_m3 LA18_m3 0.418643979
K666 LA17_m3 LA19_m3 0.301146275
K667 LA17_m3 LA20_m3 0.227589461
K668 LA17_m3 LA21_m3 0.176848393
K669 LA17_m3 LA22_m3 0.120582944
K670 LA17_m3 LA23_m3 0.060287091
K671 LA17_m3 LB0_m3 0.073131635
K672 LA17_m3 LB1_m3 0.094360913
K673 LA17_m3 LB2_m3 0.094011614
K674 LA17_m3 LB3_m3 0.107720193
K675 LA17_m3 LB4_m3 0.114393041
K676 LA17_m3 LB5_m3 0.111281987
K677 LA17_m3 LB6_m3 0.124869836
K678 LA17_m3 LB7_m3 0.134490524
K679 LA17_m3 LB8_m3 0.134427423
K680 LA17_m3 LB9_m3 0.159586030
K681 LA17_m3 LB10_m3 0.189811738
K682 LA17_m3 LB11_m3 0.184856225
K683 LA17_m3 LB12_m3 0.197421701
K684 LA17_m3 LB13_m3 0.269165341
K685 LA17_m3 LB14_m3 0.273423139
K686 LA17_m3 LB15_m3 0.379632277
K687 LA17_m3 LB16_m3 0.484820813
K688 LA17_m3 LB17_m3 0.603609066
K689 LA17_m3 LB18_m3 0.452403859
K690 LA17_m3 LB19_m3 0.305587327
K691 LA17_m3 LB20_m3 0.226292093
K692 LA17_m3 LB21_m3 0.167880487
K693 LA17_m3 LB22_m3 0.111251138
K694 LA17_m3 LB23_m3 0.060024255
K695 LA18_m3 LA19_m3 0.456310736
K696 LA18_m3 LA20_m3 0.302566297
K697 LA18_m3 LA21_m3 0.237911642
K698 LA18_m3 LA22_m3 0.151858017
K699 LA18_m3 LA23_m3 0.069941958
K700 LA18_m3 LB0_m3 0.070807875
K701 LA18_m3 LB1_m3 0.070080092
K702 LA18_m3 LB2_m3 0.079762467
K703 LA18_m3 LB3_m3 0.095019022
K704 LA18_m3 LB4_m3 0.084459712
K705 LA18_m3 LB5_m3 0.093838446
K706 LA18_m3 LB6_m3 0.108263775
K707 LA18_m3 LB7_m3 0.098456933
K708 LA18_m3 LB8_m3 0.112123026
K709 LA18_m3 LB9_m3 0.132402583
K710 LA18_m3 LB10_m3 0.151632912
K711 LA18_m3 LB11_m3 0.132079326
K712 LA18_m3 LB12_m3 0.156667232
K713 LA18_m3 LB13_m3 0.206823118
K714 LA18_m3 LB14_m3 0.203466268
K715 LA18_m3 LB15_m3 0.266197829
K716 LA18_m3 LB16_m3 0.300912192
K717 LA18_m3 LB17_m3 0.409797812
K718 LA18_m3 LB18_m3 0.579246948
K719 LA18_m3 LB19_m3 0.461372764
K720 LA18_m3 LB20_m3 0.321526083
K721 LA18_m3 LB21_m3 0.210453914
K722 LA18_m3 LB22_m3 0.144153541
K723 LA18_m3 LB23_m3 0.079984484
K724 LA19_m3 LA20_m3 0.387710467
K725 LA19_m3 LA21_m3 0.341798294
K726 LA19_m3 LA22_m3 0.184695303
K727 LA19_m3 LA23_m3 0.061849655
K728 LA19_m3 LB0_m3 0.101523326
K729 LA19_m3 LB1_m3 0.015238889
K730 LA19_m3 LB2_m3 0.084902276
K731 LA19_m3 LB3_m3 0.100997805
K732 LA19_m3 LB4_m3 0.033811707
K733 LA19_m3 LB5_m3 0.098151521
K734 LA19_m3 LB6_m3 0.114300648
K735 LA19_m3 LB7_m3 0.041668943
K736 LA19_m3 LB8_m3 0.114939500
K737 LA19_m3 LB9_m3 0.140147543
K738 LA19_m3 LB10_m3 0.117007930
K739 LA19_m3 LB11_m3 0.068338696
K740 LA19_m3 LB12_m3 0.150249353
K741 LA19_m3 LB13_m3 0.174945852
K742 LA19_m3 LB14_m3 0.201782776
K743 LA19_m3 LB15_m3 0.218697956
K744 LA19_m3 LB16_m3 0.234234495
K745 LA19_m3 LB17_m3 0.301248408
K746 LA19_m3 LB18_m3 0.451719947
K747 LA19_m3 LB19_m3 0.555806067
K748 LA19_m3 LB20_m3 0.504479908
K749 LA19_m3 LB21_m3 0.241608983
K750 LA19_m3 LB22_m3 0.195667947
K751 LA19_m3 LB23_m3 0.123366568
K752 LA20_m3 LA21_m3 0.367787341
K753 LA20_m3 LA22_m3 0.264511572
K754 LA20_m3 LA23_m3 0.162272690
K755 LA20_m3 LB0_m3 0.017803762
K756 LA20_m3 LB1_m3 0.071022635
K757 LA20_m3 LB2_m3 0.074699535
K758 LA20_m3 LB3_m3 0.005167383
K759 LA20_m3 LB4_m3 0.098696242
K760 LA20_m3 LB5_m3 0.084996819
K761 LA20_m3 LB6_m3 0.008933788
K762 LA20_m3 LB7_m3 0.111593287
K763 LA20_m3 LB8_m3 0.098544735
K764 LA20_m3 LB9_m3 0.038416134
K765 LA20_m3 LB10_m3 0.095242156
K766 LA20_m3 LB11_m3 0.136417512
K767 LA20_m3 LB12_m3 0.131384576
K768 LA20_m3 LB13_m3 0.137578763
K769 LA20_m3 LB14_m3 0.071167208
K770 LA20_m3 LB15_m3 0.164876352
K771 LA20_m3 LB16_m3 0.165625678
K772 LA20_m3 LB17_m3 0.219259345
K773 LA20_m3 LB18_m3 0.315978643
K774 LA20_m3 LB19_m3 0.505593248
K775 LA20_m3 LB20_m3 0.543318862
K776 LA20_m3 LB21_m3 0.495895400
K777 LA20_m3 LB22_m3 0.245110645
K778 LA20_m3 LB23_m3 0.078557224
K779 LA21_m3 LA22_m3 0.394223942
K780 LA21_m3 LA23_m3 0.131484376
K781 LA21_m3 LB0_m3 0.070294254
K782 LA21_m3 LB1_m3 0.014361337
K783 LA21_m3 LB2_m3 0.047724450
K784 LA21_m3 LB3_m3 0.083310830
K785 LA21_m3 LB4_m3 0.021669095
K786 LA21_m3 LB5_m3 0.055399958
K787 LA21_m3 LB6_m3 0.092573632
K788 LA21_m3 LB7_m3 0.026505936
K789 LA21_m3 LB8_m3 0.064737507
K790 LA21_m3 LB9_m3 0.105395426
K791 LA21_m3 LB10_m3 0.080126956
K792 LA21_m3 LB11_m3 0.042572826
K793 LA21_m3 LB12_m3 0.084042099
K794 LA21_m3 LB13_m3 0.110859009
K795 LA21_m3 LB14_m3 0.141277557
K796 LA21_m3 LB15_m3 0.134456229
K797 LA21_m3 LB16_m3 0.139868591
K798 LA21_m3 LB17_m3 0.167339517
K799 LA21_m3 LB18_m3 0.208873468
K800 LA21_m3 LB19_m3 0.240418668
K801 LA21_m3 LB20_m3 0.494589706
K802 LA21_m3 LB21_m3 0.575755633
K803 LA21_m3 LB22_m3 0.418945781
K804 LA21_m3 LB23_m3 0.208887370
K805 LA22_m3 LA23_m3 0.323141998
K806 LA22_m3 LB0_m3 0.018733659
K807 LA22_m3 LB1_m3 0.037742677
K808 LA22_m3 LB2_m3 0.033524379
K809 LA22_m3 LB3_m3 0.030708847
K810 LA22_m3 LB4_m3 0.040778658
K811 LA22_m3 LB5_m3 0.039101255
K812 LA22_m3 LB6_m3 0.034796724
K813 LA22_m3 LB7_m3 0.046178977
K814 LA22_m3 LB8_m3 0.046162008
K815 LA22_m3 LB9_m3 0.040049578
K816 LA22_m3 LB10_m3 0.063760133
K817 LA22_m3 LB11_m3 0.056760433
K818 LA22_m3 LB12_m3 0.062881317
K819 LA22_m3 LB13_m3 0.076023268
K820 LA22_m3 LB14_m3 0.057827519
K821 LA22_m3 LB15_m3 0.090912862
K822 LA22_m3 LB16_m3 0.102467636
K823 LA22_m3 LB17_m3 0.114373576
K824 LA22_m3 LB18_m3 0.136128234
K825 LA22_m3 LB19_m3 0.195413373
K826 LA22_m3 LB20_m3 0.245223000
K827 LA22_m3 LB21_m3 0.415749429
K828 LA22_m3 LB22_m3 0.663562374
K829 LA22_m3 LB23_m3 0.338219462
K830 LA23_m3 LB0_m3 -0.010420785
K831 LA23_m3 LB1_m3 0.036396279
K832 LA23_m3 LB2_m3 0.023094213
K833 LA23_m3 LB3_m3 -0.014009060
K834 LA23_m3 LB4_m3 0.045881318
K835 LA23_m3 LB5_m3 0.025911002
K836 LA23_m3 LB6_m3 -0.014135287
K837 LA23_m3 LB7_m3 0.050738055
K838 LA23_m3 LB8_m3 0.029693214
K839 LA23_m3 LB9_m3 -0.004653577
K840 LA23_m3 LB10_m3 0.030082818
K841 LA23_m3 LB11_m3 0.057738222
K842 LA23_m3 LB12_m3 0.039973386
K843 LA23_m3 LB13_m3 0.038966376
K844 LA23_m3 LB14_m3 0.001208473
K845 LA23_m3 LB15_m3 0.045415100
K846 LA23_m3 LB16_m3 0.045579729
K847 LA23_m3 LB17_m3 0.058133523
K848 LA23_m3 LB18_m3 0.078512842
K849 LA23_m3 LB19_m3 0.123569044
K850 LA23_m3 LB20_m3 0.078318518
K851 LA23_m3 LB21_m3 0.208422425
K852 LA23_m3 LB22_m3 0.337961256
K853 LA23_m3 LB23_m3 0.535461835
K854 LB0_m3 LB1_m3 0.017536842
K855 LB0_m3 LB2_m3 0.425425172
K856 LB0_m3 LB3_m3 0.286821966
K857 LB0_m3 LB4_m3 0.126580498
K858 LB0_m3 LB5_m3 0.289275029
K859 LB0_m3 LB6_m3 0.221195269
K860 LB0_m3 LB7_m3 0.078943042
K861 LB0_m3 LB8_m3 0.223954251
K862 LB0_m3 LB9_m3 0.232089928
K863 LB0_m3 LB10_m3 0.097098425
K864 LB0_m3 LB11_m3 0.058779315
K865 LB0_m3 LB12_m3 0.152834625
K866 LB0_m3 LB13_m3 0.135849034
K867 LB0_m3 LB14_m3 0.169583494
K868 LB0_m3 LB15_m3 0.100860682
K869 LB0_m3 LB16_m3 0.058584842
K870 LB0_m3 LB17_m3 0.082685891
K871 LB0_m3 LB18_m3 0.083701256
K872 LB0_m3 LB19_m3 0.010806667
K873 LB0_m3 LB20_m3 0.081856200
K874 LB0_m3 LB21_m3 0.009141278
K875 LB0_m3 LB22_m3 0.038192030
K876 LB0_m3 LB23_m3 0.042196908
K877 LB1_m3 LB2_m3 0.190899068
K878 LB1_m3 LB3_m3 0.252625521
K879 LB1_m3 LB4_m3 0.377958302
K880 LB1_m3 LB5_m3 0.125030886
K881 LB1_m3 LB6_m3 0.158327474
K882 LB1_m3 LB7_m3 0.286353592
K883 LB1_m3 LB8_m3 0.093755114
K884 LB1_m3 LB9_m3 0.084871724
K885 LB1_m3 LB10_m3 0.212670780
K886 LB1_m3 LB11_m3 0.199826100
K887 LB1_m3 LB12_m3 0.081255605
K888 LB1_m3 LB13_m3 0.115453494
K889 LB1_m3 LB14_m3 0.037247177
K890 LB1_m3 LB15_m3 0.107607416
K891 LB1_m3 LB16_m3 0.119770658
K892 LB1_m3 LB17_m3 0.085616370
K893 LB1_m3 LB18_m3 0.057378847
K894 LB1_m3 LB19_m3 0.103978563
K895 LB1_m3 LB20_m3 0.026050130
K896 LB1_m3 LB21_m3 0.067062076
K897 LB1_m3 LB22_m3 0.019207524
K898 LB1_m3 LB23_m3 -0.006086028
K899 LB2_m3 LB3_m3 0.234745924
K900 LB2_m3 LB4_m3 0.335321209
K901 LB2_m3 LB5_m3 0.432143904
K902 LB2_m3 LB6_m3 0.154237480
K903 LB2_m3 LB7_m3 0.224444610
K904 LB2_m3 LB8_m3 0.317181560
K905 LB2_m3 LB9_m3 0.174926633
K906 LB2_m3 LB10_m3 0.167135869
K907 LB2_m3 LB11_m3 0.166348736
K908 LB2_m3 LB12_m3 0.219588132
K909 LB2_m3 LB13_m3 0.169062544
K910 LB2_m3 LB14_m3 0.117420261
K911 LB2_m3 LB15_m3 0.134350563
K912 LB2_m3 LB16_m3 0.094092661
K913 LB2_m3 LB17_m3 0.112803630
K914 LB2_m3 LB18_m3 0.115285228
K915 LB2_m3 LB19_m3 0.077184319
K916 LB2_m3 LB20_m3 0.056961203
K917 LB2_m3 LB21_m3 0.058916774
K918 LB2_m3 LB22_m3 0.044342332
K919 LB2_m3 LB23_m3 0.017602747
K920 LB3_m3 LB4_m3 0.194141546
K921 LB3_m3 LB5_m3 0.235275941
K922 LB3_m3 LB6_m3 0.451167689
K923 LB3_m3 LB7_m3 0.112729387
K924 LB3_m3 LB8_m3 0.152932526
K925 LB3_m3 LB9_m3 0.299062384
K926 LB3_m3 LB10_m3 0.208785884
K927 LB3_m3 LB11_m3 0.072799834
K928 LB3_m3 LB12_m3 0.104644198
K929 LB3_m3 LB13_m3 0.151944677
K930 LB3_m3 LB14_m3 0.193505200
K931 LB3_m3 LB15_m3 0.125743198
K932 LB3_m3 LB16_m3 0.122646088
K933 LB3_m3 LB17_m3 0.092897995
K934 LB3_m3 LB18_m3 0.053385143
K935 LB3_m3 LB19_m3 0.029747884
K936 LB3_m3 LB20_m3 0.106054927
K937 LB3_m3 LB21_m3 0.006060032
K938 LB3_m3 LB22_m3 0.033079113
K939 LB3_m3 LB23_m3 0.049711867
K940 LB4_m3 LB5_m3 0.334817647
K941 LB4_m3 LB6_m3 0.187307576
K942 LB4_m3 LB7_m3 0.438009555
K943 LB4_m3 LB8_m3 0.220989239
K944 LB4_m3 LB9_m3 0.154374998
K945 LB4_m3 LB10_m3 0.225778015
K946 LB4_m3 LB11_m3 0.282158650
K947 LB4_m3 LB12_m3 0.159941576
K948 LB4_m3 LB13_m3 0.167557636
K949 LB4_m3 LB14_m3 0.078069607
K950 LB4_m3 LB15_m3 0.140707711
K951 LB4_m3 LB16_m3 0.115264811
K952 LB4_m3 LB17_m3 0.117155140
K953 LB4_m3 LB18_m3 0.109642517
K954 LB4_m3 LB19_m3 0.117287907
K955 LB4_m3 LB20_m3 0.029175152
K956 LB4_m3 LB21_m3 0.087946576
K957 LB4_m3 LB22_m3 0.031570197
K958 LB4_m3 LB23_m3 -0.005890640
K959 LB5_m3 LB6_m3 0.237135258
K960 LB5_m3 LB7_m3 0.334169924
K961 LB5_m3 LB8_m3 0.424902154
K962 LB5_m3 LB9_m3 0.225070271
K963 LB5_m3 LB10_m3 0.218220552
K964 LB5_m3 LB11_m3 0.206123223
K965 LB5_m3 LB12_m3 0.265800431
K966 LB5_m3 LB13_m3 0.204176879
K967 LB5_m3 LB14_m3 0.139876822
K968 LB5_m3 LB15_m3 0.160141567
K969 LB5_m3 LB16_m3 0.114302342
K970 LB5_m3 LB17_m3 0.132336651
K971 LB5_m3 LB18_m3 0.131784521
K972 LB5_m3 LB19_m3 0.090093201
K973 LB5_m3 LB20_m3 0.067139891
K974 LB5_m3 LB21_m3 0.066929829
K975 LB5_m3 LB22_m3 0.050436510
K976 LB5_m3 LB23_m3 0.020659730
K977 LB6_m3 LB7_m3 0.181367749
K978 LB6_m3 LB8_m3 0.235075399
K979 LB6_m3 LB9_m3 0.391996875
K980 LB6_m3 LB10_m3 0.266139460
K981 LB6_m3 LB11_m3 0.096700183
K982 LB6_m3 LB12_m3 0.134231851
K983 LB6_m3 LB13_m3 0.184669635
K984 LB6_m3 LB14_m3 0.226448706
K985 LB6_m3 LB15_m3 0.148526886
K986 LB6_m3 LB16_m3 0.142561548
K987 LB6_m3 LB17_m3 0.108395397
K988 LB6_m3 LB18_m3 0.063399013
K989 LB6_m3 LB19_m3 0.036343875
K990 LB6_m3 LB20_m3 0.118309517
K991 LB6_m3 LB21_m3 0.009148349
K992 LB6_m3 LB22_m3 0.037758043
K993 LB6_m3 LB23_m3 0.054456307
K994 LB7_m3 LB8_m3 0.332904160
K995 LB7_m3 LB9_m3 0.238004565
K996 LB7_m3 LB10_m3 0.303442970
K997 LB7_m3 LB11_m3 0.356487916
K998 LB7_m3 LB12_m3 0.200087398
K999 LB7_m3 LB13_m3 0.207512757
K1000 LB7_m3 LB14_m3 0.099921023
K1001 LB7_m3 LB15_m3 0.169588557
K1002 LB7_m3 LB16_m3 0.136706397
K1003 LB7_m3 LB17_m3 0.138214531
K1004 LB7_m3 LB18_m3 0.127534358
K1005 LB7_m3 LB19_m3 0.133248976
K1006 LB7_m3 LB20_m3 0.035614837
K1007 LB7_m3 LB21_m3 0.098776893
K1008 LB7_m3 LB22_m3 0.036373032
K1009 LB7_m3 LB23_m3 -0.005324874
K1010 LB8_m3 LB9_m3 0.337234935
K1011 LB8_m3 LB10_m3 0.324788443
K1012 LB8_m3 LB11_m3 0.279180335
K1013 LB8_m3 LB12_m3 0.341431114
K1014 LB8_m3 LB13_m3 0.257231325
K1015 LB8_m3 LB14_m3 0.171172407
K1016 LB8_m3 LB15_m3 0.196642446
K1017 LB8_m3 LB16_m3 0.142159948
K1018 LB8_m3 LB17_m3 0.158709787
K1019 LB8_m3 LB18_m3 0.153538915
K1020 LB8_m3 LB19_m3 0.107342549
K1021 LB8_m3 LB20_m3 0.079714565
K1022 LB8_m3 LB21_m3 0.077410364
K1023 LB8_m3 LB22_m3 0.058023321
K1024 LB8_m3 LB23_m3 0.024174423
K1025 LB9_m3 LB10_m3 0.352359406
K1026 LB9_m3 LB11_m3 0.241622327
K1027 LB9_m3 LB12_m3 0.260933068
K1028 LB9_m3 LB13_m3 0.275892632
K1029 LB9_m3 LB14_m3 0.305490671
K1030 LB9_m3 LB15_m3 0.202720901
K1031 LB9_m3 LB16_m3 0.148544632
K1032 LB9_m3 LB17_m3 0.152762438
K1033 LB9_m3 LB18_m3 0.123970296
K1034 LB9_m3 LB19_m3 0.054115273
K1035 LB9_m3 LB20_m3 0.128675694
K1036 LB9_m3 LB21_m3 0.032254189
K1037 LB9_m3 LB22_m3 0.051707458
K1038 LB9_m3 LB23_m3 0.056956108
K1039 LB10_m3 LB11_m3 0.375621321
K1040 LB10_m3 LB12_m3 0.334306316
K1041 LB10_m3 LB13_m3 0.327873538
K1042 LB10_m3 LB14_m3 0.221922953
K1043 LB10_m3 LB15_m3 0.251075515
K1044 LB10_m3 LB16_m3 0.241583558
K1045 LB10_m3 LB17_m3 0.185657660
K1046 LB10_m3 LB18_m3 0.130035747
K1047 LB10_m3 LB19_m3 0.140263337
K1048 LB10_m3 LB20_m3 0.111274629
K1049 LB10_m3 LB21_m3 0.080946399
K1050 LB10_m3 LB22_m3 0.056151145
K1051 LB10_m3 LB23_m3 0.031664066
K1052 LB11_m3 LB12_m3 0.372211824
K1053 LB11_m3 LB13_m3 0.351074575
K1054 LB11_m3 LB14_m3 0.182145703
K1055 LB11_m3 LB15_m3 0.252667066
K1056 LB11_m3 LB16_m3 0.190789347
K1057 LB11_m3 LB17_m3 0.192177868
K1058 LB11_m3 LB18_m3 0.172228022
K1059 LB11_m3 LB19_m3 0.163889982
K1060 LB11_m3 LB20_m3 0.055162304
K1061 LB11_m3 LB21_m3 0.119108422
K1062 LB11_m3 LB22_m3 0.048537717
K1063 LB11_m3 LB23_m3 -0.000118899
K1064 LB12_m3 LB13_m3 0.460970446
K1065 LB12_m3 LB14_m3 0.274001496
K1066 LB12_m3 LB15_m3 0.309586020
K1067 LB12_m3 LB16_m3 0.224477511
K1068 LB12_m3 LB17_m3 0.228616753
K1069 LB12_m3 LB18_m3 0.204737251
K1070 LB12_m3 LB19_m3 0.153316225
K1071 LB12_m3 LB20_m3 0.106361259
K1072 LB12_m3 LB21_m3 0.103832135
K1073 LB12_m3 LB22_m3 0.073493633
K1074 LB12_m3 LB23_m3 0.029953118
K1075 LB13_m3 LB14_m3 0.428950025
K1076 LB13_m3 LB15_m3 0.415152296
K1077 LB13_m3 LB16_m3 0.306674022
K1078 LB13_m3 LB17_m3 0.282552470
K1079 LB13_m3 LB18_m3 0.229526458
K1080 LB13_m3 LB19_m3 0.175383066
K1081 LB13_m3 LB20_m3 0.144893759
K1082 LB13_m3 LB21_m3 0.111856135
K1083 LB13_m3 LB22_m3 0.080826950
K1084 LB13_m3 LB23_m3 0.043565060
K1085 LB14_m3 LB15_m3 0.419035116
K1086 LB14_m3 LB16_m3 0.269014999
K1087 LB14_m3 LB17_m3 0.265150592
K1088 LB14_m3 LB18_m3 0.205972742
K1089 LB14_m3 LB19_m3 0.094467042
K1090 LB14_m3 LB20_m3 0.177174577
K1091 LB14_m3 LB21_m3 0.057111414
K1092 LB14_m3 LB22_m3 0.073387057
K1093 LB14_m3 LB23_m3 0.071719837
K1094 LB15_m3 LB16_m3 0.461448148
K1095 LB15_m3 LB17_m3 0.392472947
K1096 LB15_m3 LB18_m3 0.290752791
K1097 LB15_m3 LB19_m3 0.219255654
K1098 LB15_m3 LB20_m3 0.178623891
K1099 LB15_m3 LB21_m3 0.133451209
K1100 LB15_m3 LB22_m3 0.094969176
K1101 LB15_m3 LB23_m3 0.051686181
K1102 LB16_m3 LB17_m3 0.454481894
K1103 LB16_m3 LB18_m3 0.270986641
K1104 LB16_m3 LB19_m3 0.252247099
K1105 LB16_m3 LB20_m3 0.199067333
K1106 LB16_m3 LB21_m3 0.133264825
K1107 LB16_m3 LB22_m3 0.096788827
K1108 LB16_m3 LB23_m3 0.054519781
K1109 LB17_m3 LB18_m3 0.439615669
K1110 LB17_m3 LB19_m3 0.306081866
K1111 LB17_m3 LB20_m3 0.231656767
K1112 LB17_m3 LB21_m3 0.171388681
K1113 LB17_m3 LB22_m3 0.119106233
K1114 LB17_m3 LB23_m3 0.061430826
K1115 LB18_m3 LB19_m3 0.436771705
K1116 LB18_m3 LB20_m3 0.291875248
K1117 LB18_m3 LB21_m3 0.235785477
K1118 LB18_m3 LB22_m3 0.150415164
K1119 LB18_m3 LB23_m3 0.068901822
K1120 LB19_m3 LB20_m3 0.386389772
K1121 LB19_m3 LB21_m3 0.342490247
K1122 LB19_m3 LB22_m3 0.184739490
K1123 LB19_m3 LB23_m3 0.061568869
K1124 LB20_m3 LB21_m3 0.367357766
K1125 LB20_m3 LB22_m3 0.265938402
K1126 LB20_m3 LB23_m3 0.162795471
K1127 LB21_m3 LB22_m3 0.394451981
K1128 LB21_m3 LB23_m3 0.130735406
K1129 LB22_m3 LB23_m3 0.323862344
.ac dec 250 10k 30Meg
.meas AC M2_OUT_1MHz FIND V(m2_out) AT 1Meg
.meas AC M3_OUT_1MHz FIND V(m3_out) AT 1Meg
.backanno
.end
